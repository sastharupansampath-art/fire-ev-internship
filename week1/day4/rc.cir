RC Transient Simulation
V1 in 0 PULSE(0 5 0 1u 1u 5m 10m)
R1 in out 10k
C1 out 0 100n
.tran 10u 10m
.control
run
wrdata rc_response.txt v(out)
quit
.endc
.end
