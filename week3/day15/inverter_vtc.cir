CMOS inverter DC transfer characteristic - Level 1 learning model
VDD vdd 0 DC 1.8
VIN in 0 DC 0
.model NMOD NMOS (LEVEL=1 VTO=0.55 KP=200u LAMBDA=0.02)
.model PMOD PMOS (LEVEL=1 VTO=-0.55 KP=80u LAMBDA=0.02)
MP out in vdd vdd PMOD W=2u L=0.15u
MN out in 0 0 NMOD W=1u L=0.15u
.control
set wr_singlescale
set wr_vecnames
dc VIN 0 1.8 0.01
wrdata ../data/vtc.dat v(in) v(out)
quit
.endc
.end
