* SKY130A NMOS output characteristic
.lib "/home/sastha-rupan-s/.volare/sky130A/libs.tech/ngspice/sky130.lib.spice" tt
.option scale=1e-6
VDS d 0 0
VGS g 0 1.5
XM1 d g 0 0 sky130_fd_pr__nfet_01v8 L=0.15 W=1
.control
set wr_singlescale
dc VDS 0 1.8 0.02
wrdata data/nmos_output_1p5.dat v(d) -i(VDS)
quit
.endc
.end
