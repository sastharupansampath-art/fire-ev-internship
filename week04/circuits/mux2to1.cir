* Fire EV Internship - Week 4: Combinational CMOS Logic
* SKY130A PDK: /home/sastha-rupan-s/.volare/volare/sky130/versions/c6d73a35f524070e85faff4a6a9eef49553ebc2b/sky130A
* Typical process corner; educational circuit sizing, not sign-off design.
.lib "/home/sastha-rupan-s/.volare/volare/sky130/versions/c6d73a35f524070e85faff4a6a9eef49553ebc2b/sky130A/libs.tech/ngspice/sky130.lib.spice" tt
.param VDD=1.8
.param LCH=0.15u
.param WN=1u
.param WP=2u
* Model identifiers discovered from installed PDK:
* NMOS: sky130_fd_pr__nfet_01v8__model.0
* PMOS: sky130_fd_pr__pfet_01v8__model.0
* 2:1 MUX: Y = (NOT S AND A) OR (S AND B).
VDD vp 0 1.8
VA a 0 PULSE(0 1.8 0 100p 100p 10n 20n)
VB b 0 PULSE(1.8 0 0 100p 100p 10n 20n)
VS s 0 PULSE(0 1.8 0 100p 100p 40n 80n)
Bsb sb 0 V=1.8-V(s)
* A path enabled when S=0; B path enabled when S=1
MNA y sb a 0 sky130_fd_pr__nfet_01v8__model.0 W={WN} L={LCH}
MPA y s a vp sky130_fd_pr__pfet_01v8__model.0 W={WP} L={LCH}
MNB y s b 0 sky130_fd_pr__nfet_01v8__model.0 W={WN} L={LCH}
MPB y sb b vp sky130_fd_pr__pfet_01v8__model.0 W={WP} L={LCH}
CLOAD y 0 10f

.control
set noaskquit
tran 100p 80n
wrdata results/mux2to1_transient.dat v(a) v(b) v(s) v(y)
.endc
.end
