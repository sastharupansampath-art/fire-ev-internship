* Fire EV Internship - Week 4: Combinational CMOS Logic
* SKY130A PDK: /home/sastha-rupan-s/.volare/volare/sky130/versions/c6d73a35f524070e85faff4a6a9eef49553ebc2b/sky130A
* Typical process corner; educational circuit sizing, not sign-off design.
.lib "/home/sastha-rupan-s/.volare/volare/sky130/versions/c6d73a35f524070e85faff4a6a9eef49553ebc2b/sky130A/libs.tech/ngspice/sky130.lib.spice" tt
.param VDD=1.8
.param LCH=0.15u
.param WN=1u
.param WP=2u
* Model identifiers discovered from installed PDK:
* NMOS: sky130_fd_pr__nfet_01v8__model.0
* PMOS: sky130_fd_pr__pfet_01v8__model.0
* Transmission gate: parallel NMOS/PMOS with complementary control.
VDD vp 0 1.8
VIN din 0 PULSE(0 1.8 0 100p 100p 20n 40n)
VS s 0 PULSE(0 1.8 0 100p 100p 40n 80n)
Bsb sb 0 V=1.8-V(s)
MN out s din 0 sky130_fd_pr__nfet_01v8__model.0 W={WN} L={LCH}
MP out sb din vp sky130_fd_pr__pfet_01v8__model.0 W={WP} L={LCH}
CLOAD out 0 10f

.control
set noaskquit
tran 100p 80n
wrdata results/transmission_gate_transient.dat v(din) v(s) v(out)
.endc
.end
